* ==========================================================================
* 2LAL QUAD-RAIL INVERTER -- 8-STAGE RING
* sky130 / ngspice.  Companion to ecrl_exp1/ecrl_slowramp.sp.
* GENERATED by make_2lal_ring.py -- edit the generator, not this file.
* (Changing a top-level .param value here is fine; run_2lal_sweep.sh does.)
* --------------------------------------------------------------------------
* Replaces the open chain in 2LAL_inverter_multi_test.sp.
*
* WHY A RING
*   A 2LAL node is charged by the stage before it and restored to rest by
*   the stage AFTER it (that stage's reverse gates, switched on by the next
*   node).  The last node of an open chain has no stage after it, so it is
*   never restored; it keeps the previous stage's reverse gates on and
*   corrupts the stages before it.  In the open-chain deck this reached the
*   metered stage 4 and inflated the energy up to 47x at slow clocks.
*   A ring has no last node.  DeBenedictis tests 2LAL the same way
*   (4lc/2L.cir TWOCYCLEALL: 'cyclic shift register, data by
*   initialization'; Shift/sS2.cir and sQ2.cir).
*
* WHAT IS DIFFERENT FROM THE OPEN CHAIN
*   - no ideal input source: data is loaded by .ic and circulates
*   - no unmetered driver/load stages: all 8 stages are metered, so every
*     joule the rails deliver or recover is counted
*   - phi2 / phi3 are written as the inverse of phi0 / phi1 so all four
*     rails are already in steady state at t=0 (a delayed PULSE sits at 0
*     until its delay expires, which is not where phi2/phi3 should be)
*
* AXES (unchanged, 1:1 with the ECRL experiment)
*     TPHASE = transition time,  TRAIL = 4*TPHASE,  f_tr = 1/TPHASE
*     WN = WP, L = 0.15 um, CL on every dual-rail node
*
* WHAT AN 'OPERATION' IS
*   One quad-rail column = the a-cell plus the n-cell at one stage index
*   = 16 FETs.  For ANY data value exactly one of its two sub-chains pulses,
*   so each column switches once per rail period.  8 columns x one rail
*   period = 8 operations.
*
* SIGNAL ENCODING
*   A dual-rail pair (T,C) rests at FALSE = (0, VDD).  TRUE = T follows its
*   rail phi_m up and back down while C follows the antiphase rail phi_m+2.
* ==========================================================================

.include "./sky130_01v8_tt_fast.spice"

* ---------------------------------------------------------------- parameters
.param VDD    = 1.8
.param WN     = 1.0         ; nFET width, MICRONS   ; SWEEPVAR
.param WP     = 1.0         ; pFET width, MICRONS   ; SWEEPVAR
.param L      = 0.15        ; channel length, MICRONS
.param CL     = 25f         ; load per dual-rail node (matches ECRL's CL)

.param TPHASE = 10n                                 ; SWEEPVAR
.param TRAIL  = '4*TPHASE'  ; one full trapezoid    (== ECRL Tclock)
.param TSTEP  = 'TPHASE/500'
.param TSTOP  = '6*TRAIL+TPHASE'   ; margin: e6 is read AT 6*TRAIL

.options reltol=1e-4 abstol=1e-13 vntol=1e-7 chgtol=1e-16 gmin=1e-14
.options method=gear maxord=2

Vnb vnb 0 DC 0
Vpb vpb 0 DC {VDD}

* ---------------------------------------------------------------- power clocks
* rise / flat-high / fall / flat-low of one TPHASE each: 50% duty at the
* midpoint, 25% transition time -- Fig. 1 of the 2LAL paper.
* phi2 = VDD - phi0 and phi3 = VDD - phi1 exactly; writing them that way
* (start high, fall first) puts every rail in steady state from t=0.
* At t=0:  phi0 = 0 rising,  phi1 = 0,  phi2 = VDD falling,  phi3 = VDD.
Vp0 p0 0 PULSE(0     {VDD} 0        {TPHASE} {TPHASE} {TPHASE} {TRAIL})
Vp1 p1 0 PULSE(0     {VDD} {TPHASE} {TPHASE} {TPHASE} {TPHASE} {TRAIL})
Vp2 p2 0 PULSE({VDD} 0     0        {TPHASE} {TPHASE} {TPHASE} {TRAIL})
Vp3 p3 0 PULSE({VDD} 0     {TPHASE} {TPHASE} {TPHASE} {TPHASE} {TRAIL})

* ==========================================================================
* CELLS
* ==========================================================================
* Transmission gate: conducts s->d when the dual-rail control (gn,gp) is TRUE.
.subckt TG d gn gp s vnb vpb
xN d gn s vnb sky130_fd_pr__nfet_01v8 w={WN} l={L}
+ as='WN*L*1.77' ad='WN*L*1.77' ps='(WN+L)*2.4' pd='(WN+L)*2.4'
xP d gp s vpb sky130_fd_pr__pfet_01v8 w={WP} l={L}
+ as='WP*L*1.77' ad='WP*L*1.77' ps='(WP+L)*2.4' pd='(WP+L)*2.4'
.ends TG

* The 2LAL delay element (Fig 2c / 4lc PHAS2), 8 FETs:
*   forward pair drives the output from phi_t and its antiphase phi_t+2;
*   reverse pair restores the PREVIOUS stage's node from phi_t-1 / phi_t+1
*   once this stage's output is valid.
* Same connections as PHAS2 in DeBenedictis 4lc/2L.cir.
.subckt BUF8P inT inC outT outC L0 L1 L2 L3 vnb vpb
XF1 outT inT inC L1 vnb vpb TG          ; TRUE -> outT pulses on phi_t
XF2 outC inT inC L3 vnb vpb TG          ; TRUE -> outC pulled down by phi_t+2
XR1 inT  outT outC L0 vnb vpb TG        ; restore inT via phi_t-1
XR2 inC  outT outC L2 vnb vpb TG        ; restore inC via phi_t+1
.ends BUF8P

* ==========================================================================
* QUAD-RAIL INVERTER RING
* ==========================================================================
* Node m rides rail phi_(m mod 4).  Stage m takes node m to node m+1
* (mod 8) and is clocked (L0..L3) = phi_m .. phi_m+3.
* Every stage takes its input from the OPPOSITE sub-chain -- that crossing
* is the inversion.  8 crossings per lap is even, so the ring is
* logically consistent.

* -------- rail ammeters (0 V sources used as current probes) ---------------
Vm0 p0 r0 DC 0
Vm1 p1 r1 DC 0
Vm2 p2 r2 DC 0
Vm3 p3 r3 DC 0

* stage 0  (phi0 -> node 1 on phi1)
XP0 nT0 nC0 aT1 aC1 r0 r1 r2 r3 vnb vpb BUF8P
XN0 aT0 aC0 nT1 nC1 r0 r1 r2 r3 vnb vpb BUF8P
* stage 1  (phi1 -> node 2 on phi2)
XP1 nT1 nC1 aT2 aC2 r1 r2 r3 r0 vnb vpb BUF8P
XN1 aT1 aC1 nT2 nC2 r1 r2 r3 r0 vnb vpb BUF8P
* stage 2  (phi2 -> node 3 on phi3)
XP2 nT2 nC2 aT3 aC3 r2 r3 r0 r1 vnb vpb BUF8P
XN2 aT2 aC2 nT3 nC3 r2 r3 r0 r1 vnb vpb BUF8P
* stage 3  (phi3 -> node 4 on phi0)
XP3 nT3 nC3 aT4 aC4 r3 r0 r1 r2 vnb vpb BUF8P
XN3 aT3 aC3 nT4 nC4 r3 r0 r1 r2 vnb vpb BUF8P
* stage 4  (phi0 -> node 5 on phi1)
XP4 nT4 nC4 aT5 aC5 r0 r1 r2 r3 vnb vpb BUF8P
XN4 aT4 aC4 nT5 nC5 r0 r1 r2 r3 vnb vpb BUF8P
* stage 5  (phi1 -> node 6 on phi2)
XP5 nT5 nC5 aT6 aC6 r1 r2 r3 r0 vnb vpb BUF8P
XN5 aT5 aC5 nT6 nC6 r1 r2 r3 r0 vnb vpb BUF8P
* stage 6  (phi2 -> node 7 on phi3)
XP6 nT6 nC6 aT7 aC7 r2 r3 r0 r1 vnb vpb BUF8P
XN6 aT6 aC6 nT7 nC7 r2 r3 r0 r1 vnb vpb BUF8P
* stage 7  (phi3 -> node 0 on phi0)
XP7 nT7 nC7 aT0 aC0 r3 r0 r1 r2 vnb vpb BUF8P
XN7 aT7 aC7 nT0 nC0 r3 r0 r1 r2 vnb vpb BUF8P

* ---------------------------------------------------------------- node loads
CaT0 aT0 0 {CL}
CaC0 aC0 0 {CL}
CnT0 nT0 0 {CL}
CnC0 nC0 0 {CL}
CaT1 aT1 0 {CL}
CaC1 aC1 0 {CL}
CnT1 nT1 0 {CL}
CnC1 nC1 0 {CL}
CaT2 aT2 0 {CL}
CaC2 aC2 0 {CL}
CnT2 nT2 0 {CL}
CnC2 nC2 0 {CL}
CaT3 aT3 0 {CL}
CaC3 aC3 0 {CL}
CnT3 nT3 0 {CL}
CnC3 nC3 0 {CL}
CaT4 aT4 0 {CL}
CaC4 aC4 0 {CL}
CnT4 nT4 0 {CL}
CnC4 nC4 0 {CL}
CaT5 aT5 0 {CL}
CaC5 aC5 0 {CL}
CnT5 nT5 0 {CL}
CnC5 nC5 0 {CL}
CaT6 aT6 0 {CL}
CaC6 aC6 0 {CL}
CnT6 nT6 0 {CL}
CnC6 nC6 0 {CL}
CaT7 aT7 0 {CL}
CaC7 aC7 0 {CL}
CnT7 nT7 0 {CL}
CnC7 nC7 0 {CL}

* ==========================================================================
* ENERGY INTEGRATOR
* ==========================================================================
* A behavioural current source pushing P(t) into a 1 F capacitor makes V(e)
* the running integral of power, so the node reads directly in JOULES.
Be 0 e I = V(r0)*I(Vm0) + V(r1)*I(Vm1) + V(r2)*I(Vm2) + V(r3)*I(Vm3)
Ce e 0 1
Re e 0 1e15

* ---------------------------------------------------------------- data seed
* Nodes on phi0/phi1 are at rest at t=0 whatever they carry (their rails are
* at 0).  Each p2 node and the p3 node after it hold one data wave:
*   TRUE sub-chain  -> T = VDD (its rail), C = 0 (the antiphase rail)
*   other sub-chain -> at rest, T = 0, C = VDD
* Successive waves have opposite polarity, so each node's data alternates
* every rail period.  To test a constant pattern instead, give every wave
* the same polarity (swap a<->n on the .ic lines of every other wave).
.ic V(e)=0
.ic V(aT0)=0 V(aC0)={VDD} V(nT0)=0 V(nC0)={VDD}
.ic V(aT1)=0 V(aC1)={VDD} V(nT1)=0 V(nC1)={VDD}
.ic V(aT2)={VDD} V(aC2)=0 V(nT2)=0 V(nC2)={VDD}   ; wave 0, TRUE on a
.ic V(aT3)=0 V(aC3)={VDD} V(nT3)={VDD} V(nC3)=0   ; wave 0, TRUE on n
.ic V(aT4)=0 V(aC4)={VDD} V(nT4)=0 V(nC4)={VDD}
.ic V(aT5)=0 V(aC5)={VDD} V(nT5)=0 V(nC5)={VDD}
.ic V(aT6)=0 V(aC6)={VDD} V(nT6)={VDD} V(nC6)=0   ; wave 1, TRUE on n
.ic V(aT7)={VDD} V(aC7)=0 V(nT7)=0 V(nC7)={VDD}   ; wave 1, TRUE on a

.tran {TSTEP} {TSTOP} uic

* ==========================================================================
* FUNCTIONAL CHECKS
* ==========================================================================
* For every node, in two consecutive rail periods (so it carries both data
* polarities), with ts = start of that node's pulse = P*TRAIL + (m%4)*TPHASE:
*   TRUE sub-chain : T high and C low mid-plateau   (ts + 1.5*TPHASE)
*                    T low and C high mid-rest      (ts + 3.5*TPHASE)
*   other sub-chain: T never rises, C never falls   (MAX/MIN over ts..ts+4T)
* chkhi_* must read > 0.9*VDD, chklo_* must read < 0.1*VDD.
* run_2lal_sweep.sh enforces both at every sweep point.
* node 0, period 3: TRUE on a
.meas tran chkhi_aT0_p3_plat FIND V(aT0) AT='3*TRAIL+0*TPHASE+1.5*TPHASE'
.meas tran chklo_aC0_p3_plat FIND V(aC0) AT='3*TRAIL+0*TPHASE+1.5*TPHASE'
.meas tran chklo_aT0_p3_rest FIND V(aT0) AT='3*TRAIL+0*TPHASE+3.5*TPHASE'
.meas tran chkhi_aC0_p3_rest FIND V(aC0) AT='3*TRAIL+0*TPHASE+3.5*TPHASE'
.meas tran chklo_nT0_p3_max MAX V(nT0) FROM='3*TRAIL+0*TPHASE' TO='3*TRAIL+0*TPHASE+4*TPHASE'
.meas tran chkhi_nC0_p3_min MIN V(nC0) FROM='3*TRAIL+0*TPHASE' TO='3*TRAIL+0*TPHASE+4*TPHASE'
* node 1, period 3: TRUE on n
.meas tran chkhi_nT1_p3_plat FIND V(nT1) AT='3*TRAIL+1*TPHASE+1.5*TPHASE'
.meas tran chklo_nC1_p3_plat FIND V(nC1) AT='3*TRAIL+1*TPHASE+1.5*TPHASE'
.meas tran chklo_nT1_p3_rest FIND V(nT1) AT='3*TRAIL+1*TPHASE+3.5*TPHASE'
.meas tran chkhi_nC1_p3_rest FIND V(nC1) AT='3*TRAIL+1*TPHASE+3.5*TPHASE'
.meas tran chklo_aT1_p3_max MAX V(aT1) FROM='3*TRAIL+1*TPHASE' TO='3*TRAIL+1*TPHASE+4*TPHASE'
.meas tran chkhi_aC1_p3_min MIN V(aC1) FROM='3*TRAIL+1*TPHASE' TO='3*TRAIL+1*TPHASE+4*TPHASE'
* node 2, period 3: TRUE on a
.meas tran chkhi_aT2_p3_plat FIND V(aT2) AT='3*TRAIL+2*TPHASE+1.5*TPHASE'
.meas tran chklo_aC2_p3_plat FIND V(aC2) AT='3*TRAIL+2*TPHASE+1.5*TPHASE'
.meas tran chklo_aT2_p3_rest FIND V(aT2) AT='3*TRAIL+2*TPHASE+3.5*TPHASE'
.meas tran chkhi_aC2_p3_rest FIND V(aC2) AT='3*TRAIL+2*TPHASE+3.5*TPHASE'
.meas tran chklo_nT2_p3_max MAX V(nT2) FROM='3*TRAIL+2*TPHASE' TO='3*TRAIL+2*TPHASE+4*TPHASE'
.meas tran chkhi_nC2_p3_min MIN V(nC2) FROM='3*TRAIL+2*TPHASE' TO='3*TRAIL+2*TPHASE+4*TPHASE'
* node 3, period 3: TRUE on n
.meas tran chkhi_nT3_p3_plat FIND V(nT3) AT='3*TRAIL+3*TPHASE+1.5*TPHASE'
.meas tran chklo_nC3_p3_plat FIND V(nC3) AT='3*TRAIL+3*TPHASE+1.5*TPHASE'
.meas tran chklo_nT3_p3_rest FIND V(nT3) AT='3*TRAIL+3*TPHASE+3.5*TPHASE'
.meas tran chkhi_nC3_p3_rest FIND V(nC3) AT='3*TRAIL+3*TPHASE+3.5*TPHASE'
.meas tran chklo_aT3_p3_max MAX V(aT3) FROM='3*TRAIL+3*TPHASE' TO='3*TRAIL+3*TPHASE+4*TPHASE'
.meas tran chkhi_aC3_p3_min MIN V(aC3) FROM='3*TRAIL+3*TPHASE' TO='3*TRAIL+3*TPHASE+4*TPHASE'
* node 4, period 3: TRUE on n
.meas tran chkhi_nT4_p3_plat FIND V(nT4) AT='3*TRAIL+0*TPHASE+1.5*TPHASE'
.meas tran chklo_nC4_p3_plat FIND V(nC4) AT='3*TRAIL+0*TPHASE+1.5*TPHASE'
.meas tran chklo_nT4_p3_rest FIND V(nT4) AT='3*TRAIL+0*TPHASE+3.5*TPHASE'
.meas tran chkhi_nC4_p3_rest FIND V(nC4) AT='3*TRAIL+0*TPHASE+3.5*TPHASE'
.meas tran chklo_aT4_p3_max MAX V(aT4) FROM='3*TRAIL+0*TPHASE' TO='3*TRAIL+0*TPHASE+4*TPHASE'
.meas tran chkhi_aC4_p3_min MIN V(aC4) FROM='3*TRAIL+0*TPHASE' TO='3*TRAIL+0*TPHASE+4*TPHASE'
* node 5, period 3: TRUE on a
.meas tran chkhi_aT5_p3_plat FIND V(aT5) AT='3*TRAIL+1*TPHASE+1.5*TPHASE'
.meas tran chklo_aC5_p3_plat FIND V(aC5) AT='3*TRAIL+1*TPHASE+1.5*TPHASE'
.meas tran chklo_aT5_p3_rest FIND V(aT5) AT='3*TRAIL+1*TPHASE+3.5*TPHASE'
.meas tran chkhi_aC5_p3_rest FIND V(aC5) AT='3*TRAIL+1*TPHASE+3.5*TPHASE'
.meas tran chklo_nT5_p3_max MAX V(nT5) FROM='3*TRAIL+1*TPHASE' TO='3*TRAIL+1*TPHASE+4*TPHASE'
.meas tran chkhi_nC5_p3_min MIN V(nC5) FROM='3*TRAIL+1*TPHASE' TO='3*TRAIL+1*TPHASE+4*TPHASE'
* node 6, period 3: TRUE on n
.meas tran chkhi_nT6_p3_plat FIND V(nT6) AT='3*TRAIL+2*TPHASE+1.5*TPHASE'
.meas tran chklo_nC6_p3_plat FIND V(nC6) AT='3*TRAIL+2*TPHASE+1.5*TPHASE'
.meas tran chklo_nT6_p3_rest FIND V(nT6) AT='3*TRAIL+2*TPHASE+3.5*TPHASE'
.meas tran chkhi_nC6_p3_rest FIND V(nC6) AT='3*TRAIL+2*TPHASE+3.5*TPHASE'
.meas tran chklo_aT6_p3_max MAX V(aT6) FROM='3*TRAIL+2*TPHASE' TO='3*TRAIL+2*TPHASE+4*TPHASE'
.meas tran chkhi_aC6_p3_min MIN V(aC6) FROM='3*TRAIL+2*TPHASE' TO='3*TRAIL+2*TPHASE+4*TPHASE'
* node 7, period 3: TRUE on a
.meas tran chkhi_aT7_p3_plat FIND V(aT7) AT='3*TRAIL+3*TPHASE+1.5*TPHASE'
.meas tran chklo_aC7_p3_plat FIND V(aC7) AT='3*TRAIL+3*TPHASE+1.5*TPHASE'
.meas tran chklo_aT7_p3_rest FIND V(aT7) AT='3*TRAIL+3*TPHASE+3.5*TPHASE'
.meas tran chkhi_aC7_p3_rest FIND V(aC7) AT='3*TRAIL+3*TPHASE+3.5*TPHASE'
.meas tran chklo_nT7_p3_max MAX V(nT7) FROM='3*TRAIL+3*TPHASE' TO='3*TRAIL+3*TPHASE+4*TPHASE'
.meas tran chkhi_nC7_p3_min MIN V(nC7) FROM='3*TRAIL+3*TPHASE' TO='3*TRAIL+3*TPHASE+4*TPHASE'
* node 0, period 4: TRUE on n
.meas tran chkhi_nT0_p4_plat FIND V(nT0) AT='4*TRAIL+0*TPHASE+1.5*TPHASE'
.meas tran chklo_nC0_p4_plat FIND V(nC0) AT='4*TRAIL+0*TPHASE+1.5*TPHASE'
.meas tran chklo_nT0_p4_rest FIND V(nT0) AT='4*TRAIL+0*TPHASE+3.5*TPHASE'
.meas tran chkhi_nC0_p4_rest FIND V(nC0) AT='4*TRAIL+0*TPHASE+3.5*TPHASE'
.meas tran chklo_aT0_p4_max MAX V(aT0) FROM='4*TRAIL+0*TPHASE' TO='4*TRAIL+0*TPHASE+4*TPHASE'
.meas tran chkhi_aC0_p4_min MIN V(aC0) FROM='4*TRAIL+0*TPHASE' TO='4*TRAIL+0*TPHASE+4*TPHASE'
* node 1, period 4: TRUE on a
.meas tran chkhi_aT1_p4_plat FIND V(aT1) AT='4*TRAIL+1*TPHASE+1.5*TPHASE'
.meas tran chklo_aC1_p4_plat FIND V(aC1) AT='4*TRAIL+1*TPHASE+1.5*TPHASE'
.meas tran chklo_aT1_p4_rest FIND V(aT1) AT='4*TRAIL+1*TPHASE+3.5*TPHASE'
.meas tran chkhi_aC1_p4_rest FIND V(aC1) AT='4*TRAIL+1*TPHASE+3.5*TPHASE'
.meas tran chklo_nT1_p4_max MAX V(nT1) FROM='4*TRAIL+1*TPHASE' TO='4*TRAIL+1*TPHASE+4*TPHASE'
.meas tran chkhi_nC1_p4_min MIN V(nC1) FROM='4*TRAIL+1*TPHASE' TO='4*TRAIL+1*TPHASE+4*TPHASE'
* node 2, period 4: TRUE on n
.meas tran chkhi_nT2_p4_plat FIND V(nT2) AT='4*TRAIL+2*TPHASE+1.5*TPHASE'
.meas tran chklo_nC2_p4_plat FIND V(nC2) AT='4*TRAIL+2*TPHASE+1.5*TPHASE'
.meas tran chklo_nT2_p4_rest FIND V(nT2) AT='4*TRAIL+2*TPHASE+3.5*TPHASE'
.meas tran chkhi_nC2_p4_rest FIND V(nC2) AT='4*TRAIL+2*TPHASE+3.5*TPHASE'
.meas tran chklo_aT2_p4_max MAX V(aT2) FROM='4*TRAIL+2*TPHASE' TO='4*TRAIL+2*TPHASE+4*TPHASE'
.meas tran chkhi_aC2_p4_min MIN V(aC2) FROM='4*TRAIL+2*TPHASE' TO='4*TRAIL+2*TPHASE+4*TPHASE'
* node 3, period 4: TRUE on a
.meas tran chkhi_aT3_p4_plat FIND V(aT3) AT='4*TRAIL+3*TPHASE+1.5*TPHASE'
.meas tran chklo_aC3_p4_plat FIND V(aC3) AT='4*TRAIL+3*TPHASE+1.5*TPHASE'
.meas tran chklo_aT3_p4_rest FIND V(aT3) AT='4*TRAIL+3*TPHASE+3.5*TPHASE'
.meas tran chkhi_aC3_p4_rest FIND V(aC3) AT='4*TRAIL+3*TPHASE+3.5*TPHASE'
.meas tran chklo_nT3_p4_max MAX V(nT3) FROM='4*TRAIL+3*TPHASE' TO='4*TRAIL+3*TPHASE+4*TPHASE'
.meas tran chkhi_nC3_p4_min MIN V(nC3) FROM='4*TRAIL+3*TPHASE' TO='4*TRAIL+3*TPHASE+4*TPHASE'
* node 4, period 4: TRUE on a
.meas tran chkhi_aT4_p4_plat FIND V(aT4) AT='4*TRAIL+0*TPHASE+1.5*TPHASE'
.meas tran chklo_aC4_p4_plat FIND V(aC4) AT='4*TRAIL+0*TPHASE+1.5*TPHASE'
.meas tran chklo_aT4_p4_rest FIND V(aT4) AT='4*TRAIL+0*TPHASE+3.5*TPHASE'
.meas tran chkhi_aC4_p4_rest FIND V(aC4) AT='4*TRAIL+0*TPHASE+3.5*TPHASE'
.meas tran chklo_nT4_p4_max MAX V(nT4) FROM='4*TRAIL+0*TPHASE' TO='4*TRAIL+0*TPHASE+4*TPHASE'
.meas tran chkhi_nC4_p4_min MIN V(nC4) FROM='4*TRAIL+0*TPHASE' TO='4*TRAIL+0*TPHASE+4*TPHASE'
* node 5, period 4: TRUE on n
.meas tran chkhi_nT5_p4_plat FIND V(nT5) AT='4*TRAIL+1*TPHASE+1.5*TPHASE'
.meas tran chklo_nC5_p4_plat FIND V(nC5) AT='4*TRAIL+1*TPHASE+1.5*TPHASE'
.meas tran chklo_nT5_p4_rest FIND V(nT5) AT='4*TRAIL+1*TPHASE+3.5*TPHASE'
.meas tran chkhi_nC5_p4_rest FIND V(nC5) AT='4*TRAIL+1*TPHASE+3.5*TPHASE'
.meas tran chklo_aT5_p4_max MAX V(aT5) FROM='4*TRAIL+1*TPHASE' TO='4*TRAIL+1*TPHASE+4*TPHASE'
.meas tran chkhi_aC5_p4_min MIN V(aC5) FROM='4*TRAIL+1*TPHASE' TO='4*TRAIL+1*TPHASE+4*TPHASE'
* node 6, period 4: TRUE on a
.meas tran chkhi_aT6_p4_plat FIND V(aT6) AT='4*TRAIL+2*TPHASE+1.5*TPHASE'
.meas tran chklo_aC6_p4_plat FIND V(aC6) AT='4*TRAIL+2*TPHASE+1.5*TPHASE'
.meas tran chklo_aT6_p4_rest FIND V(aT6) AT='4*TRAIL+2*TPHASE+3.5*TPHASE'
.meas tran chkhi_aC6_p4_rest FIND V(aC6) AT='4*TRAIL+2*TPHASE+3.5*TPHASE'
.meas tran chklo_nT6_p4_max MAX V(nT6) FROM='4*TRAIL+2*TPHASE' TO='4*TRAIL+2*TPHASE+4*TPHASE'
.meas tran chkhi_nC6_p4_min MIN V(nC6) FROM='4*TRAIL+2*TPHASE' TO='4*TRAIL+2*TPHASE+4*TPHASE'
* node 7, period 4: TRUE on n
.meas tran chkhi_nT7_p4_plat FIND V(nT7) AT='4*TRAIL+3*TPHASE+1.5*TPHASE'
.meas tran chklo_nC7_p4_plat FIND V(nC7) AT='4*TRAIL+3*TPHASE+1.5*TPHASE'
.meas tran chklo_nT7_p4_rest FIND V(nT7) AT='4*TRAIL+3*TPHASE+3.5*TPHASE'
.meas tran chkhi_nC7_p4_rest FIND V(nC7) AT='4*TRAIL+3*TPHASE+3.5*TPHASE'
.meas tran chklo_aT7_p4_max MAX V(aT7) FROM='4*TRAIL+3*TPHASE' TO='4*TRAIL+3*TPHASE+4*TPHASE'
.meas tran chkhi_aC7_p4_min MIN V(aC7) FROM='4*TRAIL+3*TPHASE' TO='4*TRAIL+3*TPHASE+4*TPHASE'

* ==========================================================================
* ENERGY -- 8 columns, one operation each per rail period
* ==========================================================================
* Rail periods 0-1 are left to settle; 2..5 are measured.
.meas tran e2 FIND V(e) AT='2*TRAIL'
.meas tran e3 FIND V(e) AT='3*TRAIL'
.meas tran e4 FIND V(e) AT='4*TRAIL'
.meas tran e6 FIND V(e) AT='6*TRAIL'
* E_A: rail period 2 alone        (8 operations)
.meas tran E_A PARAM='(e3-e2)/8'
* E_B: rail period 3 alone        (8 operations) -- must match E_A if settled
.meas tran E_B PARAM='(e4-e3)/8'
* E_C: periods 2..5, the reported value (32 operations)
.meas tran E_C PARAM='(e6-e2)/32'

* -------- run check -----------------------------------------------------
* p1 starts rising at TPHASE and takes TPHASE to reach VDD, so it crosses
* VDD/2 at exactly 1.5*TPHASE.  run_2lal_sweep.sh reads this back to prove
* the simulator used the TPHASE the sweep asked for.
.meas tran chk_tphase WHEN V(p1)='VDD/2' RISE=1

.end

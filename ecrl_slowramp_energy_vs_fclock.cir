* ============================================================
* ECRL inverter (adiabatic slow-ramp input, alternating data): energy per operation vs power-clock frequency\nsky130 tt, VDD 1.8 V, L = 0.15 um, CL = 25 fF
*
* X-axis : Power-clock frequency  f_clock = 1/(4*TPHASE)  =  operation rate   (MHz)
* Y-axis : energy per operation (fJ)
*
* Generated by make_plots.py from the sweep CSV -- do not hand-edit.
* ============================================================

.control

set noaskquit

let FTR = vector(7)
let FTR[0] = 2.5
let FTR[1] = 5
let FTR[2] = 12.5
let FTR[3] = 25
let FTR[4] = 50
let FTR[5] = 125
let FTR[6] = 250

* W = 0.84 um
let E084 = vector(7)
let E084[0] = 12.6076
let E084[1] = 14.5825
let E084[2] = 18.3081
let E084[3] = 22.5451
let E084[4] = 28.9209
let E084[5] = 43.1529
let E084[6] = 59.5888

* W = 1.0 um
let E100 = vector(7)
let E100[0] = 12.4589
let E100[1] = 14.3651
let E100[2] = 17.8262
let E100[3] = 21.6584
let E100[4] = 27.3168
let E100[5] = 39.8223
let E100[6] = 54.6948

* W = 1.2 um
let E120 = vector(7)
let E120[0] = 12.5598
let E120[1] = 14.4423
let E120[2] = 17.7364
let E120[3] = 21.282
let E120[4] = 26.4078
let E120[5] = 37.5837
let E120[6] = 51.1151

* W = 1.5 um
let E150 = vector(7)
let E150[0] = 11.9683
let E150[1] = 13.7022
let E150[2] = 16.6752
let E150[3] = 19.8145
let E150[4] = 24.2835
let E150[5] = 33.9302
let E150[6] = 46.0545

* W = 2.0 um
let E200 = vector(7)
let E200[0] = 11.7318
let E200[1] = 13.3868
let E200[2] = 16.1483
let E200[3] = 18.9715
let E200[4] = 22.8807
let E200[5] = 31.0587
let E200[6] = 41.3977

* W = 3.0 um
let E300 = vector(7)
let E300[0] = 11.5505
let E300[1] = 13.1027
let E300[2] = 15.6168
let E300[3] = 18.0893
let E300[4] = 21.4023
let E300[5] = 28.083
let E300[6] = 36.432

print FTR
print E084
print E100
print E120
print E150
print E200
print E300

plot E084 vs FTR E100 vs FTR E120 vs FTR E150 vs FTR E200 vs FTR E300 vs FTR

.endc

.end

* ============================================================
* ECRL ENERGY vs TPHASE
* All transistor widths
*
* Data source:
*   width_sweep.csv
*
* Units:
*   TPHASE -> ns
*   ENERGY -> fJ
* ============================================================

.control

set noaskquit

* ------------------------------------------------------------
* X-axis
* ------------------------------------------------------------

let TPH = vector(7)

let TPH[0] = 1
let TPH[1] = 2
let TPH[2] = 5
let TPH[3] = 10
let TPH[4] = 20
let TPH[5] = 50
let TPH[6] = 100

* W = 0.84 um
let E084 = vector(7)
let E084[0] = 63.1894
let E084[1] = 46.3956
let E084[2] = 29.0713
let E084[3] = 18.5206
let E084[4] = 10.3207
let E084[5] = 6.10257
let E084[6] = 5.45023

* W = 1.0 um
let E100 = vector(7)
let E100[0] = 58.7173
let E100[1] = 43.4898
let E100[2] = 27.8825
let E100[3] = 18.0491
let E100[4] = 10.0837
let E100[5] = 6.00806
let E100[6] = 5.36221

* W = 1.2 um
let E120 = vector(7)
let E120[0] = 55.673
let E120[1] = 41.8344
let E120[2] = 27.7057
let E120[3] = 18.4166
let E120[4] = 10.527
let E120[5] = 5.70686
let E120[6] = 5.0968

* W = 1.5 um
let E150 = vector(7)
let E150[0] = 51.1719
let E150[1] = 38.6602
let E150[2] = 25.0106
let E150[3] = 15.8216
let E150[4] = 7.99557
let E150[5] = 5.37634
let E150[6] = 4.83337

* W = 2.0 um
let E200 = vector(7)
let E200[0] = 47.5726
let E200[1] = 36.7993
let E200[2] = 23.9341
let E200[3] = 14.8967
let E200[4] = 7.25506
let E200[5] = 5.43074
let E200[6] = 4.93971

* W = 3.0 um
let E300 = vector(7)
let E300[0] = 44.3245
let E300[1] = 35.3816
let E300[2] = 22.288
let E300[3] = 13.0664
let E300[4] = 6.14665
let E300[5] = 5.14124
let E300[6] = 4.72765

* ------------------------------------------------------------
* DISPLAY DATA
* ------------------------------------------------------------

print TPH
print E084
print E100
print E120
print E150
print E200
print E300

* ------------------------------------------------------------
* PLOT ALL WIDTHS
* ------------------------------------------------------------

plot E084 vs TPH E100 vs TPH E120 vs TPH E150 vs TPH E200 vs TPH E300 vs TPH
.endc

.end

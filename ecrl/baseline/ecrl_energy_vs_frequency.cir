* ============================================================
* ECRL INVERTER
* Energy per operation vs Power-Clock Frequency
*
* Data obtained from the completed SKY130 ECRL simulations
*
* X-axis : Power-clock frequency (MHz)
* Y-axis : Energy per operation (fJ)
*
* f_clock = 1 / (4*Tphase)
* ============================================================

.control

* ------------------------------------------------------------
* POWER-CLOCK FREQUENCY
* Corresponding Tphase values:
*
* Tphase = 100, 50, 20, 10, 5, 2, 1 ns
*
* f = 1/(4*Tphase)
*
* Therefore:
* 2.5, 5, 12.5, 25, 50, 125, 250 MHz
* ------------------------------------------------------------

let FREQ = vector(7)

let FREQ[0] = 2.5
let FREQ[1] = 5
let FREQ[2] = 12.5
let FREQ[3] = 25
let FREQ[4] = 50
let FREQ[5] = 125
let FREQ[6] = 250

* ============================================================
* W = 0.84 um
* ============================================================

let E084 = vector(7)

let E084[0] = 5.45023
let E084[1] = 6.10257
let E084[2] = 10.3207
let E084[3] = 18.5206
let E084[4] = 29.0713
let E084[5] = 46.3956
let E084[6] = 63.1894

* ============================================================
* W = 1.0 um
* ============================================================

let E100 = vector(7)

let E100[0] = 5.36221
let E100[1] = 6.00806
let E100[2] = 10.0837
let E100[3] = 18.0491
let E100[4] = 27.8825
let E100[5] = 43.4898
let E100[6] = 58.7173

* ============================================================
* W = 1.2 um
* ============================================================

let E120 = vector(7)

let E120[0] = 5.09680
let E120[1] = 5.70686
let E120[2] = 10.5270
let E120[3] = 18.4166
let E120[4] = 27.7057
let E120[5] = 41.8344
let E120[6] = 55.6730

* ============================================================
* W = 1.5 um
* ============================================================

let E150 = vector(7)

let E150[0] = 4.83337
let E150[1] = 5.37634
let E150[2] = 7.99557
let E150[3] = 15.8216
let E150[4] = 25.0106
let E150[5] = 38.6602
let E150[6] = 51.1719

* ============================================================
* W = 2.0 um
* ============================================================

let E200 = vector(7)

let E200[0] = 4.93971
let E200[1] = 5.43074
let E200[2] = 7.25506
let E200[3] = 14.8967
let E200[4] = 23.9341
let E200[5] = 36.7993
let E200[6] = 47.5726

* ============================================================
* W = 3.0 um
* ============================================================

let E300 = vector(7)

let E300[0] = 4.72765
let E300[1] = 5.14124
let E300[2] = 6.14665
let E300[3] = 13.0664
let E300[4] = 22.2880
let E300[5] = 35.3816
let E300[6] = 44.3245

* ============================================================
* PRINT DATA
* ============================================================

print FREQ
print E084
print E100
print E120
print E150
print E200
print E300

* ============================================================
* PLOT ALL SIX WIDTHS
* ============================================================

plot E084 vs FREQ E100 vs FREQ E120 vs FREQ E150 vs FREQ E200 vs FREQ E300 vs FREQ

.endc

.end

* ============================================================
* ECRL INVERTER
* Energy per operation vs Transition Frequency
*
* Based on the completed SKY130 ECRL simulations
*
* X-axis : Power-clock transition frequency (MHz)
* Y-axis : Energy per operation / cycle (fJ)
*
* Transition frequency:
*
*       f_tr = 1 / Tphase
*
* Therefore:
*
* Tphase = 100 ns -> 10 MHz
* Tphase =  50 ns -> 20 MHz
* Tphase =  20 ns -> 50 MHz
* Tphase =  10 ns -> 100 MHz
* Tphase =   5 ns -> 200 MHz
* Tphase =   2 ns -> 500 MHz
* Tphase =   1 ns -> 1000 MHz
*
* ECRL power clock itself has:
*
*       Tclock = 4*Tphase
*
* so this X-axis is specifically the inverse of the
* individual transition/phase duration.
* ============================================================

.control

set noaskquit

* ============================================================
* TRANSITION FREQUENCY
* ============================================================

let FTR = vector(7)

let FTR[0] = 10
let FTR[1] = 20
let FTR[2] = 50
let FTR[3] = 100
let FTR[4] = 200
let FTR[5] = 500
let FTR[6] = 1000

* ============================================================
* W = 0.84 um
*
* Original data:
* Tphase = 1,2,5,10,20,50,100 ns
*
* Reordered for increasing transition frequency
* ============================================================

let E084 = vector(7)

let E084[0] = 5.45023
let E084[1] = 6.10257
let E084[2] = 10.3207
let E084[3] = 18.5206
let E084[4] = 29.0713
let E084[5] = 46.3956
let E084[6] = 63.1894

* ============================================================
* W = 1.0 um
* ============================================================

let E100 = vector(7)

let E100[0] = 5.36221
let E100[1] = 6.00806
let E100[2] = 10.0837
let E100[3] = 18.0491
let E100[4] = 27.8825
let E100[5] = 43.4898
let E100[6] = 58.7173

* ============================================================
* W = 1.2 um
* ============================================================

let E120 = vector(7)

let E120[0] = 5.09680
let E120[1] = 5.70686
let E120[2] = 10.5270
let E120[3] = 18.4166
let E120[4] = 27.7057
let E120[5] = 41.8344
let E120[6] = 55.6730

* ============================================================
* W = 1.5 um
* ============================================================

let E150 = vector(7)

let E150[0] = 4.83337
let E150[1] = 5.37634
let E150[2] = 7.99557
let E150[3] = 15.8216
let E150[4] = 25.0106
let E150[5] = 38.6602
let E150[6] = 51.1719

* ============================================================
* W = 2.0 um
* ============================================================

let E200 = vector(7)

let E200[0] = 4.93971
let E200[1] = 5.43074
let E200[2] = 7.25506
let E200[3] = 14.8967
let E200[4] = 23.9341
let E200[5] = 36.7993
let E200[6] = 47.5726

* ============================================================
* W = 3.0 um
* ============================================================

let E300 = vector(7)

let E300[0] = 4.72765
let E300[1] = 5.14124
let E300[2] = 6.14665
let E300[3] = 13.0664
let E300[4] = 22.2880
let E300[5] = 35.3816
let E300[6] = 44.3245

* ============================================================
* PRINT DATA
* ============================================================

print FTR
print E084
print E100
print E120
print E150
print E200
print E300

* ============================================================
* PLOT ALL SIX WIDTHS
* ============================================================

plot E084 vs FTR E100 vs FTR E120 vs FTR E150 vs FTR E200 vs FTR E300 vs FTR

.endc

.end

* ============================================================
* ECRL ENERGY vs TRANSITION FREQUENCY
*
* X-axis : Transition Frequency (MHz)
* Y-axis : Energy per operation (pJ)
*
* f_transition = 1 / Tphase
*
* Display range:
*   X = 0 to 100 MHz
*   Y = 0 to 0.03 pJ
* ============================================================

.control

set noaskquit

* ============================================================
* TRANSITION FREQUENCY
* ============================================================

let FTR = vector(7)

let FTR[0] = 10
let FTR[1] = 20
let FTR[2] = 50
let FTR[3] = 100
let FTR[4] = 200
let FTR[5] = 500
let FTR[6] = 1000

* ============================================================
* W = 0.84 um
* Values converted from fJ to pJ
* ============================================================

let E084 = vector(7)

let E084[0] = 0.00545023
let E084[1] = 0.00610257
let E084[2] = 0.0103207
let E084[3] = 0.0185206
let E084[4] = 0.0290713
let E084[5] = 0.0463956
let E084[6] = 0.0631894

* ============================================================
* W = 1.0 um
* ============================================================

let E100 = vector(7)

let E100[0] = 0.00536221
let E100[1] = 0.00600806
let E100[2] = 0.0100837
let E100[3] = 0.0180491
let E100[4] = 0.0278825
let E100[5] = 0.0434898
let E100[6] = 0.0587173

* ============================================================
* W = 1.2 um
* ============================================================

let E120 = vector(7)

let E120[0] = 0.00509680
let E120[1] = 0.00570686
let E120[2] = 0.0105270
let E120[3] = 0.0184166
let E120[4] = 0.0277057
let E120[5] = 0.0418344
let E120[6] = 0.0556730

* ============================================================
* W = 1.5 um
* ============================================================

let E150 = vector(7)

let E150[0] = 0.00483337
let E150[1] = 0.00537634
let E150[2] = 0.00799557
let E150[3] = 0.0158216
let E150[4] = 0.0250106
let E150[5] = 0.0386602
let E150[6] = 0.0511719

* ============================================================
* W = 2.0 um
* ============================================================

let E200 = vector(7)

let E200[0] = 0.00493971
let E200[1] = 0.00543074
let E200[2] = 0.00725506
let E200[3] = 0.0148967
let E200[4] = 0.0239341
let E200[5] = 0.0367993
let E200[6] = 0.0475726

* ============================================================
* W = 3.0 um
* ============================================================

let E300 = vector(7)

let E300[0] = 0.00472765
let E300[1] = 0.00514124
let E300[2] = 0.00614665
let E300[3] = 0.0130664
let E300[4] = 0.0222880
let E300[5] = 0.0353816
let E300[6] = 0.0443245

* ============================================================
* PLOT
* ============================================================

plot E084 vs FTR E100 vs FTR E120 vs FTR E150 vs FTR E200 vs FTR E300 vs FTR xlimit 0 100 ylimit 0 0.03

.endc

.end
